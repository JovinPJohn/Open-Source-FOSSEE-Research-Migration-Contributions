.title KiCad schematic
v6 A0 GND pulse
v5 A1 GND pulse
U12 A0 plot_v1
U3 B1 Net-_U3-Pad2_ adc_bridge_1
U5 B0 Net-_U5-Pad2_ adc_bridge_1
U1 B2 Net-_U1-Pad2_ adc_bridge_1
v4 A2 GND pulse
U10 A1 plot_v1
U8 A2 plot_v1
v2 B1 GND pulse
U6 B0 plot_v1
v3 B0 GND pulse
U2 B2 plot_v1
v1 B2 GND pulse
U4 B1 plot_v1
U9 A1 Net-_U9-Pad2_ adc_bridge_1
U7 A2 Net-_U7-Pad2_ adc_bridge_1
U11 A0 Net-_U11-Pad2_ adc_bridge_1
X3 Net-_U14-Pad3_ Net-_U15-Pad3_ Net-_U23-Pad1_ Net-_X1-Pad3_ half_adder
X5 Net-_X1-Pad4_ Net-_U18-Pad3_ Net-_U24-Pad1_ Net-_X5-Pad4_ half_adder
X1 Net-_U16-Pad3_ Net-_U17-Pad3_ Net-_X1-Pad3_ Net-_X1-Pad4_ Net-_X1-Pad5_ full_adder
X2 Net-_U19-Pad3_ Net-_U20-Pad3_ Net-_X1-Pad5_ Net-_X2-Pad4_ Net-_X2-Pad5_ full_adder
X6 Net-_X5-Pad4_ Net-_X2-Pad4_ Net-_U25-Pad1_ Net-_X4-Pad3_ half_adder
X4 Net-_X2-Pad5_ Net-_U21-Pad3_ Net-_X4-Pad3_ Net-_U26-Pad1_ Net-_U27-Pad1_ full_adder
U31 P3 plot_v1
U25 Net-_U25-Pad1_ P3 dac_bridge_1
U30 P2 plot_v1
U24 Net-_U24-Pad1_ P2 dac_bridge_1
U33 P5 plot_v1
U32 P4 plot_v1
U27 Net-_U27-Pad1_ P5 dac_bridge_1
U26 Net-_U26-Pad1_ P4 dac_bridge_1
U28 P0 plot_v1
U29 P1 plot_v1
U23 Net-_U23-Pad1_ P1 dac_bridge_1
U22 Net-_U13-Pad3_ P0 dac_bridge_1
U19 Net-_U7-Pad2_ Net-_U3-Pad2_ Net-_U19-Pad3_ d_and
U18 Net-_U11-Pad2_ Net-_U1-Pad2_ Net-_U18-Pad3_ d_and
U20 Net-_U9-Pad2_ Net-_U1-Pad2_ Net-_U20-Pad3_ d_and
U21 Net-_U7-Pad2_ Net-_U1-Pad2_ Net-_U21-Pad3_ d_and
U14 Net-_U9-Pad2_ Net-_U5-Pad2_ Net-_U14-Pad3_ d_and
U16 Net-_U7-Pad2_ Net-_U5-Pad2_ Net-_U16-Pad3_ d_and
U17 Net-_U9-Pad2_ Net-_U3-Pad2_ Net-_U17-Pad3_ d_and
U15 Net-_U11-Pad2_ Net-_U3-Pad2_ Net-_U15-Pad3_ d_and
U13 Net-_U11-Pad2_ Net-_U5-Pad2_ Net-_U13-Pad3_ d_and
.end
